// Transient testbench for alu8 - operand isolation OFF
// generated by gen_netlist.py ; vectors = model/test_vectors.csv
// 30 vectors x 10 ns.  Run:  spectre tb_alu8_noiso.scs +aps -format psfxl -raw ./psf_noiso
simulator lang=spectre
global 0

include "/path/to/gpdk045/models/spectre/gpdk045.scs" section=tt
include "cells.scs"
include "alu8.scs"

parameters vdd=1.0 isooff=1 cl=5f

// ---- supplies (one per block -> per-block power)
Vctrl (vdd_ctrl 0) vsource dc=vdd type=dc
Varith (vdd_arith 0) vsource dc=vdd type=dc
Vmul (vdd_mul 0) vsource dc=vdd type=dc
Vlogic (vdd_logic 0) vsource dc=vdd type=dc
Vshift (vdd_shift 0) vsource dc=vdd type=dc
VISO (ISO_OFF 0) vsource dc=isooff*vdd type=dc

// ---- input stimulus: 0/1 V PWL, scaled to vdd by a VCVS (so vdd can be swept)
VA0_raw (A0_raw 0) vsource type=pwl wave=[ 0n 1 50n 1 50.05n 0 60n 0 60.05n 1 80n 1 80.05n 0 110n 0 110.05n 1 120n 1 120.05n 0 210n 0 210.05n 1 240n 1 240.05n 0 250n 0 250.05n 1 260n 1 260.05n 0 290n 0 290.05n 1 300n 1 ]
EA0 (A0 0 A0_raw 0) vcvs gain=vdd
VA1_raw (A1_raw 0) vsource type=pwl wave=[ 0n 0 10n 0 10.05n 1 30n 1 30.05n 0 40n 0 40.05n 1 50n 1 50.05n 0 60n 0 60.05n 1 80n 1 80.05n 0 110n 0 110.05n 1 120n 1 120.05n 0 130n 0 130.05n 1 210n 1 210.05n 0 250n 0 250.05n 1 260n 1 260.05n 0 300n 0 ]
EA1 (A1 0 A1_raw 0) vcvs gain=vdd
VA2_raw (A2_raw 0) vsource type=pwl wave=[ 0n 1 50n 1 50.05n 0 60n 0 60.05n 1 80n 1 80.05n 0 100n 0 100.05n 1 120n 1 120.05n 0 250n 0 250.05n 1 260n 1 260.05n 0 290n 0 290.05n 1 300n 1 ]
EA2 (A2 0 A2_raw 0) vcvs gain=vdd
VA3_raw (A3_raw 0) vsource type=pwl wave=[ 0n 1 40n 1 40.05n 0 60n 0 60.05n 1 80n 1 80.05n 0 100n 0 100.05n 1 120n 1 120.05n 0 130n 0 130.05n 1 210n 1 210.05n 0 300n 0 ]
EA3 (A3 0 A3_raw 0) vcvs gain=vdd
VA4_raw (A4_raw 0) vsource type=pwl wave=[ 0n 0 10n 0 10.05n 1 30n 1 30.05n 0 40n 0 40.05n 1 50n 1 50.05n 0 70n 0 70.05n 1 90n 1 90.05n 0 110n 0 110.05n 1 130n 1 130.05n 0 250n 0 250.05n 1 270n 1 270.05n 0 300n 0 ]
EA4 (A4 0 A4_raw 0) vcvs gain=vdd
VA5_raw (A5_raw 0) vsource type=pwl wave=[ 0n 1 40n 1 40.05n 0 70n 0 70.05n 1 80n 1 80.05n 0 110n 0 110.05n 1 120n 1 120.05n 0 160n 0 160.05n 1 170n 1 170.05n 0 250n 0 250.05n 1 260n 1 260.05n 0 270n 0 270.05n 1 280n 1 280.05n 0 290n 0 290.05n 1 300n 1 ]
EA5 (A5 0 A5_raw 0) vcvs gain=vdd
VA6_raw (A6_raw 0) vsource type=pwl wave=[ 0n 0 10n 0 10.05n 1 30n 1 30.05n 0 70n 0 70.05n 1 80n 1 80.05n 0 110n 0 110.05n 1 120n 1 120.05n 0 130n 0 130.05n 1 160n 1 160.05n 0 170n 0 170.05n 1 210n 1 210.05n 0 240n 0 240.05n 1 250n 1 250.05n 0 300n 0 ]
EA6 (A6 0 A6_raw 0) vcvs gain=vdd
VA7_raw (A7_raw 0) vsource type=pwl wave=[ 0n 0 10n 0 10.05n 1 20n 1 20.05n 0 50n 0 50.05n 1 60n 1 60.05n 0 70n 0 70.05n 1 80n 1 80.05n 0 110n 0 110.05n 1 120n 1 120.05n 0 130n 0 130.05n 1 240n 1 240.05n 0 290n 0 290.05n 1 300n 1 ]
EA7 (A7 0 A7_raw 0) vcvs gain=vdd
VB0_raw (B0_raw 0) vsource type=pwl wave=[ 0n 1 60n 1 60.05n 0 100n 0 100.05n 1 120n 1 120.05n 0 130n 0 130.05n 1 160n 1 160.05n 0 180n 0 180.05n 1 210n 1 210.05n 0 250n 0 250.05n 1 260n 1 260.05n 0 300n 0 ]
EB0 (B0 0 B0_raw 0) vcvs gain=vdd
VB1_raw (B1_raw 0) vsource type=pwl wave=[ 0n 1 10n 1 10.05n 0 30n 0 30.05n 1 40n 1 40.05n 0 100n 0 100.05n 1 120n 1 120.05n 0 130n 0 130.05n 1 170n 1 170.05n 0 180n 0 180.05n 1 210n 1 210.05n 0 250n 0 250.05n 1 260n 1 260.05n 0 290n 0 290.05n 1 300n 1 ]
EB1 (B1 0 B1_raw 0) vcvs gain=vdd
VB2_raw (B2_raw 0) vsource type=pwl wave=[ 0n 1 10n 1 10.05n 0 30n 0 30.05n 1 50n 1 50.05n 0 110n 0 110.05n 1 120n 1 120.05n 0 130n 0 130.05n 1 160n 1 160.05n 0 180n 0 180.05n 1 210n 1 210.05n 0 250n 0 250.05n 1 260n 1 260.05n 0 300n 0 ]
EB2 (B2 0 B2_raw 0) vcvs gain=vdd
VB3_raw (B3_raw 0) vsource type=pwl wave=[ 0n 0 40n 0 40.05n 1 50n 1 50.05n 0 100n 0 100.05n 1 120n 1 120.05n 0 130n 0 130.05n 1 170n 1 170.05n 0 180n 0 180.05n 1 210n 1 210.05n 0 290n 0 290.05n 1 300n 1 ]
EB3 (B3 0 B3_raw 0) vcvs gain=vdd
VB4_raw (B4_raw 0) vsource type=pwl wave=[ 0n 1 10n 1 10.05n 0 30n 0 30.05n 1 40n 1 40.05n 0 110n 0 110.05n 1 160n 1 160.05n 0 180n 0 180.05n 1 210n 1 210.05n 0 250n 0 250.05n 1 260n 1 260.05n 0 270n 0 270.05n 1 280n 1 280.05n 0 290n 0 290.05n 1 300n 1 ]
EB4 (B4 0 B4_raw 0) vcvs gain=vdd
VB5_raw (B5_raw 0) vsource type=pwl wave=[ 0n 0 40n 0 40.05n 1 50n 1 50.05n 0 110n 0 110.05n 1 120n 1 120.05n 0 160n 0 160.05n 1 170n 1 170.05n 0 250n 0 250.05n 1 270n 1 270.05n 0 300n 0 ]
EB5 (B5 0 B5_raw 0) vcvs gain=vdd
VB6_raw (B6_raw 0) vsource type=pwl wave=[ 0n 0 110n 0 110.05n 1 120n 1 120.05n 0 130n 0 130.05n 1 160n 1 160.05n 0 180n 0 180.05n 1 210n 1 210.05n 0 290n 0 290.05n 1 300n 1 ]
EB6 (B6 0 B6_raw 0) vcvs gain=vdd
VB7_raw (B7_raw 0) vsource type=pwl wave=[ 0n 0 110n 0 110.05n 1 120n 1 120.05n 0 160n 0 160.05n 1 170n 1 170.05n 0 300n 0 ]
EB7 (B7 0 B7_raw 0) vcvs gain=vdd
VOP0_raw (OP0_raw 0) vsource type=pwl wave=[ 0n 0 30n 0 30.05n 1 60n 1 60.05n 0 80n 0 80.05n 1 100n 1 100.05n 0 130n 0 130.05n 1 140n 1 140.05n 0 150n 0 150.05n 1 170n 1 170.05n 0 180n 0 180.05n 1 190n 1 190.05n 0 200n 0 200.05n 1 210n 1 210.05n 0 220n 0 220.05n 1 230n 1 230.05n 0 250n 0 250.05n 1 280n 1 280.05n 0 300n 0 ]
EOP0 (OP0 0 OP0_raw 0) vcvs gain=vdd
VOP1_raw (OP1_raw 0) vsource type=pwl wave=[ 0n 0 60n 0 60.05n 1 100n 1 100.05n 0 140n 0 140.05n 1 170n 1 170.05n 0 190n 0 190.05n 1 210n 1 210.05n 0 230n 0 230.05n 1 280n 1 280.05n 0 300n 0 ]
EOP1 (OP1 0 OP1_raw 0) vcvs gain=vdd
VOP2_raw (OP2_raw 0) vsource type=pwl wave=[ 0n 0 100n 0 100.05n 1 170n 1 170.05n 0 210n 0 210.05n 1 280n 1 280.05n 0 290n 0 290.05n 1 300n 1 ]
EOP2 (OP2 0 OP2_raw 0) vcvs gain=vdd
VOP3_raw (OP3_raw 0) vsource type=pwl wave=[ 0n 0 170n 0 170.05n 1 280n 1 280.05n 0 300n 0 ]
EOP3 (OP3 0 OP3_raw 0) vcvs gain=vdd

// ---- device under test
XALU (A0 A1 A2 A3 A4 A5 A6 A7 B0 B1 B2 B3 B4 B5 B6 B7 OP0 OP1 OP2 OP3 ISO_OFF Y0 Y1 Y2 Y3 Y4 Y5 Y6 Y7 YH0 YH1 YH2 YH3 YH4 YH5 YH6 YH7 C Z N V WE vdd_ctrl vdd_arith vdd_mul vdd_logic vdd_shift 0) alu8

// ---- output loads
CL_Y0 (Y0 0) capacitor c=cl
CL_Y1 (Y1 0) capacitor c=cl
CL_Y2 (Y2 0) capacitor c=cl
CL_Y3 (Y3 0) capacitor c=cl
CL_Y4 (Y4 0) capacitor c=cl
CL_Y5 (Y5 0) capacitor c=cl
CL_Y6 (Y6 0) capacitor c=cl
CL_Y7 (Y7 0) capacitor c=cl
CL_YH0 (YH0 0) capacitor c=cl
CL_YH1 (YH1 0) capacitor c=cl
CL_YH2 (YH2 0) capacitor c=cl
CL_YH3 (YH3 0) capacitor c=cl
CL_YH4 (YH4 0) capacitor c=cl
CL_YH5 (YH5 0) capacitor c=cl
CL_YH6 (YH6 0) capacitor c=cl
CL_YH7 (YH7 0) capacitor c=cl
CL_C (C 0) capacitor c=cl
CL_Z (Z 0) capacitor c=cl
CL_N (N 0) capacitor c=cl
CL_V (V 0) capacitor c=cl
CL_WE (WE 0) capacitor c=cl

// ---- analysis
simulatorOptions options temp=27 tnom=27 reltol=1e-3 vabstol=1e-6 iabstol=1e-12
tran1 tran stop=300n errpreset=moderate
save A0 A1 A2 A3 A4 A5 A6 A7 B0 B1 B2 B3 B4 B5 B6 B7 OP0 OP1 OP2 OP3 ISO_OFF Y0 Y1 Y2 Y3 Y4 Y5 Y6 Y7 YH0 YH1 YH2 YH3 YH4 YH5 YH6 YH7 C Z N V WE
save Vctrl:p Varith:p Vmul:p Vlogic:p Vshift:p
