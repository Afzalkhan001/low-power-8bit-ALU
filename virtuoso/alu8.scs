// 8-bit low-power ALU, transistor level  (generated by gen_netlist.py from model/alu_gates.py)
// Separate supply pins per block let you measure each block's power.
simulator lang=spectre

subckt alu8 (A0 A1 A2 A3 A4 A5 A6 A7 B0 B1 B2 B3 B4 B5 B6 B7 OP0 OP1 OP2 OP3 ISO_OFF Y0 Y1 Y2 Y3 Y4 Y5 Y6 Y7 YH0 YH1 YH2 YH3 YH4 YH5 YH6 YH7 C Z N V WE vdd_ctrl vdd_arith vdd_mul vdd_logic vdd_shift vss)
    // ---------------- ctrl ----------------
    I0_nOP0 (OP0 nOP0 vdd_ctrl vss) inv
    I1_nOP1 (OP1 nOP1 vdd_ctrl vss) inv
    I2_nOP2 (OP2 nOP2 vdd_ctrl vss) inv
    I3_nOP3 (OP3 nOP3 vdd_ctrl vss) inv
    I4_nand01 (OP0 OP1 nand01 vdd_ctrl vss) nand2
    I5_nand23 (OP2 OP3 nand23 vdd_ctrl vss) nand2
    I6_is1111 (nand01 nand23 is1111 vdd_ctrl vss) nor2
    I7_WE (nand01 nand23 WE vdd_ctrl vss) or2
    I8_n3n2 (nOP3 nOP2 n3n2 vdd_ctrl vss) and2
    I9_n3p2 (nOP3 OP2 n3p2 vdd_ctrl vss) and2
    I10_p3n2 (OP3 nOP2 p3n2 vdd_ctrl vss) and2
    I11_p3p2 (OP3 OP2 p3p2 vdd_ctrl vss) and2
    I12_or10 (OP1 OP0 or10 vdd_ctrl vss) or2
    I13_nor10 (OP1 OP0 nor10 vdd_ctrl vss) nor2
    I14_EN_ARITH (n3n2 is1111 EN_ARITH vdd_ctrl vss) or2
    I15_EN_MUL (n3p2 nor10 EN_MUL vdd_ctrl vss) and2
    I16_en_lg_a (n3p2 or10 en_lg_a vdd_ctrl vss) and2
    I17_EN_LOGIC (en_lg_a p3n2 EN_LOGIC vdd_ctrl vss) or2
    I18_EN_SHIFT (p3p2 nand01 EN_SHIFT vdd_ctrl vss) and2
    I19_ISO_EN_AR (EN_ARITH ISO_OFF ISO_EN_AR vdd_ctrl vss) or2
    I20_ISO_EN_MU (EN_MUL ISO_OFF ISO_EN_MU vdd_ctrl vss) or2
    I21_ISO_EN_LG (EN_LOGIC ISO_OFF ISO_EN_LG vdd_ctrl vss) or2
    I22_ISO_EN_SH (EN_SHIFT ISO_OFF ISO_EN_SH vdd_ctrl vss) or2
    I23_ar_a0 (A0 ISO_EN_AR ar_a0 vdd_ctrl vss) and2
    I24_ar_a1 (A1 ISO_EN_AR ar_a1 vdd_ctrl vss) and2
    I25_ar_a2 (A2 ISO_EN_AR ar_a2 vdd_ctrl vss) and2
    I26_ar_a3 (A3 ISO_EN_AR ar_a3 vdd_ctrl vss) and2
    I27_ar_a4 (A4 ISO_EN_AR ar_a4 vdd_ctrl vss) and2
    I28_ar_a5 (A5 ISO_EN_AR ar_a5 vdd_ctrl vss) and2
    I29_ar_a6 (A6 ISO_EN_AR ar_a6 vdd_ctrl vss) and2
    I30_ar_a7 (A7 ISO_EN_AR ar_a7 vdd_ctrl vss) and2
    I31_ar_b0 (B0 ISO_EN_AR ar_b0 vdd_ctrl vss) and2
    I32_ar_b1 (B1 ISO_EN_AR ar_b1 vdd_ctrl vss) and2
    I33_ar_b2 (B2 ISO_EN_AR ar_b2 vdd_ctrl vss) and2
    I34_ar_b3 (B3 ISO_EN_AR ar_b3 vdd_ctrl vss) and2
    I35_ar_b4 (B4 ISO_EN_AR ar_b4 vdd_ctrl vss) and2
    I36_ar_b5 (B5 ISO_EN_AR ar_b5 vdd_ctrl vss) and2
    I37_ar_b6 (B6 ISO_EN_AR ar_b6 vdd_ctrl vss) and2
    I38_ar_b7 (B7 ISO_EN_AR ar_b7 vdd_ctrl vss) and2
    I39_mu_a0 (A0 ISO_EN_MU mu_a0 vdd_ctrl vss) and2
    I40_mu_a1 (A1 ISO_EN_MU mu_a1 vdd_ctrl vss) and2
    I41_mu_a2 (A2 ISO_EN_MU mu_a2 vdd_ctrl vss) and2
    I42_mu_a3 (A3 ISO_EN_MU mu_a3 vdd_ctrl vss) and2
    I43_mu_a4 (A4 ISO_EN_MU mu_a4 vdd_ctrl vss) and2
    I44_mu_a5 (A5 ISO_EN_MU mu_a5 vdd_ctrl vss) and2
    I45_mu_a6 (A6 ISO_EN_MU mu_a6 vdd_ctrl vss) and2
    I46_mu_a7 (A7 ISO_EN_MU mu_a7 vdd_ctrl vss) and2
    I47_mu_b0 (B0 ISO_EN_MU mu_b0 vdd_ctrl vss) and2
    I48_mu_b1 (B1 ISO_EN_MU mu_b1 vdd_ctrl vss) and2
    I49_mu_b2 (B2 ISO_EN_MU mu_b2 vdd_ctrl vss) and2
    I50_mu_b3 (B3 ISO_EN_MU mu_b3 vdd_ctrl vss) and2
    I51_mu_b4 (B4 ISO_EN_MU mu_b4 vdd_ctrl vss) and2
    I52_mu_b5 (B5 ISO_EN_MU mu_b5 vdd_ctrl vss) and2
    I53_mu_b6 (B6 ISO_EN_MU mu_b6 vdd_ctrl vss) and2
    I54_mu_b7 (B7 ISO_EN_MU mu_b7 vdd_ctrl vss) and2
    I55_lg_a0 (A0 ISO_EN_LG lg_a0 vdd_ctrl vss) and2
    I56_lg_a1 (A1 ISO_EN_LG lg_a1 vdd_ctrl vss) and2
    I57_lg_a2 (A2 ISO_EN_LG lg_a2 vdd_ctrl vss) and2
    I58_lg_a3 (A3 ISO_EN_LG lg_a3 vdd_ctrl vss) and2
    I59_lg_a4 (A4 ISO_EN_LG lg_a4 vdd_ctrl vss) and2
    I60_lg_a5 (A5 ISO_EN_LG lg_a5 vdd_ctrl vss) and2
    I61_lg_a6 (A6 ISO_EN_LG lg_a6 vdd_ctrl vss) and2
    I62_lg_a7 (A7 ISO_EN_LG lg_a7 vdd_ctrl vss) and2
    I63_lg_b0 (B0 ISO_EN_LG lg_b0 vdd_ctrl vss) and2
    I64_lg_b1 (B1 ISO_EN_LG lg_b1 vdd_ctrl vss) and2
    I65_lg_b2 (B2 ISO_EN_LG lg_b2 vdd_ctrl vss) and2
    I66_lg_b3 (B3 ISO_EN_LG lg_b3 vdd_ctrl vss) and2
    I67_lg_b4 (B4 ISO_EN_LG lg_b4 vdd_ctrl vss) and2
    I68_lg_b5 (B5 ISO_EN_LG lg_b5 vdd_ctrl vss) and2
    I69_lg_b6 (B6 ISO_EN_LG lg_b6 vdd_ctrl vss) and2
    I70_lg_b7 (B7 ISO_EN_LG lg_b7 vdd_ctrl vss) and2
    I71_sh_a0 (A0 ISO_EN_SH sh_a0 vdd_ctrl vss) and2
    I72_sh_a1 (A1 ISO_EN_SH sh_a1 vdd_ctrl vss) and2
    I73_sh_a2 (A2 ISO_EN_SH sh_a2 vdd_ctrl vss) and2
    I74_sh_a3 (A3 ISO_EN_SH sh_a3 vdd_ctrl vss) and2
    I75_sh_a4 (A4 ISO_EN_SH sh_a4 vdd_ctrl vss) and2
    I76_sh_a5 (A5 ISO_EN_SH sh_a5 vdd_ctrl vss) and2
    I77_sh_a6 (A6 ISO_EN_SH sh_a6 vdd_ctrl vss) and2
    I78_sh_a7 (A7 ISO_EN_SH sh_a7 vdd_ctrl vss) and2
    // ---------------- arith ----------------
    I79_ar_passb (nOP1 OP3 ar_passb vdd_arith vss) or2
    I80_ar_x01 (OP0 OP1 ar_x01 vdd_arith vss) xor2
    I81_ar_cinr (ar_x01 OP3 ar_cinr vdd_arith vss) or2
    I82_ar_inv (OP0 ISO_EN_AR ar_inv vdd_arith vss) and2
    I83_ar_c0 (ar_cinr ISO_EN_AR ar_c0 vdd_arith vss) and2
    I84_ar_bp0 (ar_b0 ar_passb ar_bp0 vdd_arith vss) and2
    I85_ar_bc0 (ar_bp0 ar_inv ar_bc0 vdd_arith vss) xor2
    I86_ar_s0 (ar_a0 ar_bc0 ar_c0 ar_s0 ar_c1 vdd_arith vss) fa
    I87_ar_bp1 (ar_b1 ar_passb ar_bp1 vdd_arith vss) and2
    I88_ar_bc1 (ar_bp1 ar_inv ar_bc1 vdd_arith vss) xor2
    I89_ar_s1 (ar_a1 ar_bc1 ar_c1 ar_s1 ar_c2 vdd_arith vss) fa
    I90_ar_bp2 (ar_b2 ar_passb ar_bp2 vdd_arith vss) and2
    I91_ar_bc2 (ar_bp2 ar_inv ar_bc2 vdd_arith vss) xor2
    I92_ar_s2 (ar_a2 ar_bc2 ar_c2 ar_s2 ar_c3 vdd_arith vss) fa
    I93_ar_bp3 (ar_b3 ar_passb ar_bp3 vdd_arith vss) and2
    I94_ar_bc3 (ar_bp3 ar_inv ar_bc3 vdd_arith vss) xor2
    I95_ar_s3 (ar_a3 ar_bc3 ar_c3 ar_s3 ar_c4 vdd_arith vss) fa
    I96_ar_bp4 (ar_b4 ar_passb ar_bp4 vdd_arith vss) and2
    I97_ar_bc4 (ar_bp4 ar_inv ar_bc4 vdd_arith vss) xor2
    I98_ar_s4 (ar_a4 ar_bc4 ar_c4 ar_s4 ar_c5 vdd_arith vss) fa
    I99_ar_bp5 (ar_b5 ar_passb ar_bp5 vdd_arith vss) and2
    I100_ar_bc5 (ar_bp5 ar_inv ar_bc5 vdd_arith vss) xor2
    I101_ar_s5 (ar_a5 ar_bc5 ar_c5 ar_s5 ar_c6 vdd_arith vss) fa
    I102_ar_bp6 (ar_b6 ar_passb ar_bp6 vdd_arith vss) and2
    I103_ar_bc6 (ar_bp6 ar_inv ar_bc6 vdd_arith vss) xor2
    I104_ar_s6 (ar_a6 ar_bc6 ar_c6 ar_s6 ar_c7 vdd_arith vss) fa
    I105_ar_bp7 (ar_b7 ar_passb ar_bp7 vdd_arith vss) and2
    I106_ar_bc7 (ar_bp7 ar_inv ar_bc7 vdd_arith vss) xor2
    I107_ar_s7 (ar_a7 ar_bc7 ar_c7 ar_s7 ar_c8 vdd_arith vss) fa
    I108_ar_v (ar_c8 ar_c7 ar_v vdd_arith vss) xor2
    // ---------------- mul ----------------
    I109_mu_pp0_0 (mu_a0 mu_b0 mu_pp0_0 vdd_mul vss) and2
    I110_mu_pp0_1 (mu_a1 mu_b0 mu_pp0_1 vdd_mul vss) and2
    I111_mu_pp0_2 (mu_a2 mu_b0 mu_pp0_2 vdd_mul vss) and2
    I112_mu_pp0_3 (mu_a3 mu_b0 mu_pp0_3 vdd_mul vss) and2
    I113_mu_pp0_4 (mu_a4 mu_b0 mu_pp0_4 vdd_mul vss) and2
    I114_mu_pp0_5 (mu_a5 mu_b0 mu_pp0_5 vdd_mul vss) and2
    I115_mu_pp0_6 (mu_a6 mu_b0 mu_pp0_6 vdd_mul vss) and2
    I116_mu_pp0_7 (mu_a7 mu_b0 mu_pp0_7 vdd_mul vss) and2
    I117_mu_pp1_0 (mu_a0 mu_b1 mu_pp1_0 vdd_mul vss) and2
    I118_mu_pp1_1 (mu_a1 mu_b1 mu_pp1_1 vdd_mul vss) and2
    I119_mu_pp1_2 (mu_a2 mu_b1 mu_pp1_2 vdd_mul vss) and2
    I120_mu_pp1_3 (mu_a3 mu_b1 mu_pp1_3 vdd_mul vss) and2
    I121_mu_pp1_4 (mu_a4 mu_b1 mu_pp1_4 vdd_mul vss) and2
    I122_mu_pp1_5 (mu_a5 mu_b1 mu_pp1_5 vdd_mul vss) and2
    I123_mu_pp1_6 (mu_a6 mu_b1 mu_pp1_6 vdd_mul vss) and2
    I124_mu_pp1_7 (mu_a7 mu_b1 mu_pp1_7 vdd_mul vss) and2
    I125_mu_pp2_0 (mu_a0 mu_b2 mu_pp2_0 vdd_mul vss) and2
    I126_mu_pp2_1 (mu_a1 mu_b2 mu_pp2_1 vdd_mul vss) and2
    I127_mu_pp2_2 (mu_a2 mu_b2 mu_pp2_2 vdd_mul vss) and2
    I128_mu_pp2_3 (mu_a3 mu_b2 mu_pp2_3 vdd_mul vss) and2
    I129_mu_pp2_4 (mu_a4 mu_b2 mu_pp2_4 vdd_mul vss) and2
    I130_mu_pp2_5 (mu_a5 mu_b2 mu_pp2_5 vdd_mul vss) and2
    I131_mu_pp2_6 (mu_a6 mu_b2 mu_pp2_6 vdd_mul vss) and2
    I132_mu_pp2_7 (mu_a7 mu_b2 mu_pp2_7 vdd_mul vss) and2
    I133_mu_pp3_0 (mu_a0 mu_b3 mu_pp3_0 vdd_mul vss) and2
    I134_mu_pp3_1 (mu_a1 mu_b3 mu_pp3_1 vdd_mul vss) and2
    I135_mu_pp3_2 (mu_a2 mu_b3 mu_pp3_2 vdd_mul vss) and2
    I136_mu_pp3_3 (mu_a3 mu_b3 mu_pp3_3 vdd_mul vss) and2
    I137_mu_pp3_4 (mu_a4 mu_b3 mu_pp3_4 vdd_mul vss) and2
    I138_mu_pp3_5 (mu_a5 mu_b3 mu_pp3_5 vdd_mul vss) and2
    I139_mu_pp3_6 (mu_a6 mu_b3 mu_pp3_6 vdd_mul vss) and2
    I140_mu_pp3_7 (mu_a7 mu_b3 mu_pp3_7 vdd_mul vss) and2
    I141_mu_pp4_0 (mu_a0 mu_b4 mu_pp4_0 vdd_mul vss) and2
    I142_mu_pp4_1 (mu_a1 mu_b4 mu_pp4_1 vdd_mul vss) and2
    I143_mu_pp4_2 (mu_a2 mu_b4 mu_pp4_2 vdd_mul vss) and2
    I144_mu_pp4_3 (mu_a3 mu_b4 mu_pp4_3 vdd_mul vss) and2
    I145_mu_pp4_4 (mu_a4 mu_b4 mu_pp4_4 vdd_mul vss) and2
    I146_mu_pp4_5 (mu_a5 mu_b4 mu_pp4_5 vdd_mul vss) and2
    I147_mu_pp4_6 (mu_a6 mu_b4 mu_pp4_6 vdd_mul vss) and2
    I148_mu_pp4_7 (mu_a7 mu_b4 mu_pp4_7 vdd_mul vss) and2
    I149_mu_pp5_0 (mu_a0 mu_b5 mu_pp5_0 vdd_mul vss) and2
    I150_mu_pp5_1 (mu_a1 mu_b5 mu_pp5_1 vdd_mul vss) and2
    I151_mu_pp5_2 (mu_a2 mu_b5 mu_pp5_2 vdd_mul vss) and2
    I152_mu_pp5_3 (mu_a3 mu_b5 mu_pp5_3 vdd_mul vss) and2
    I153_mu_pp5_4 (mu_a4 mu_b5 mu_pp5_4 vdd_mul vss) and2
    I154_mu_pp5_5 (mu_a5 mu_b5 mu_pp5_5 vdd_mul vss) and2
    I155_mu_pp5_6 (mu_a6 mu_b5 mu_pp5_6 vdd_mul vss) and2
    I156_mu_pp5_7 (mu_a7 mu_b5 mu_pp5_7 vdd_mul vss) and2
    I157_mu_pp6_0 (mu_a0 mu_b6 mu_pp6_0 vdd_mul vss) and2
    I158_mu_pp6_1 (mu_a1 mu_b6 mu_pp6_1 vdd_mul vss) and2
    I159_mu_pp6_2 (mu_a2 mu_b6 mu_pp6_2 vdd_mul vss) and2
    I160_mu_pp6_3 (mu_a3 mu_b6 mu_pp6_3 vdd_mul vss) and2
    I161_mu_pp6_4 (mu_a4 mu_b6 mu_pp6_4 vdd_mul vss) and2
    I162_mu_pp6_5 (mu_a5 mu_b6 mu_pp6_5 vdd_mul vss) and2
    I163_mu_pp6_6 (mu_a6 mu_b6 mu_pp6_6 vdd_mul vss) and2
    I164_mu_pp6_7 (mu_a7 mu_b6 mu_pp6_7 vdd_mul vss) and2
    I165_mu_pp7_0 (mu_a0 mu_b7 mu_pp7_0 vdd_mul vss) and2
    I166_mu_pp7_1 (mu_a1 mu_b7 mu_pp7_1 vdd_mul vss) and2
    I167_mu_pp7_2 (mu_a2 mu_b7 mu_pp7_2 vdd_mul vss) and2
    I168_mu_pp7_3 (mu_a3 mu_b7 mu_pp7_3 vdd_mul vss) and2
    I169_mu_pp7_4 (mu_a4 mu_b7 mu_pp7_4 vdd_mul vss) and2
    I170_mu_pp7_5 (mu_a5 mu_b7 mu_pp7_5 vdd_mul vss) and2
    I171_mu_pp7_6 (mu_a6 mu_b7 mu_pp7_6 vdd_mul vss) and2
    I172_mu_pp7_7 (mu_a7 mu_b7 mu_pp7_7 vdd_mul vss) and2
    I173_mu_s1_0 (mu_pp0_1 mu_pp1_0 vss mu_s1_0 mu_c1_0 vdd_mul vss) fa
    I174_mu_s1_1 (mu_pp0_2 mu_pp1_1 mu_c1_0 mu_s1_1 mu_c1_1 vdd_mul vss) fa
    I175_mu_s1_2 (mu_pp0_3 mu_pp1_2 mu_c1_1 mu_s1_2 mu_c1_2 vdd_mul vss) fa
    I176_mu_s1_3 (mu_pp0_4 mu_pp1_3 mu_c1_2 mu_s1_3 mu_c1_3 vdd_mul vss) fa
    I177_mu_s1_4 (mu_pp0_5 mu_pp1_4 mu_c1_3 mu_s1_4 mu_c1_4 vdd_mul vss) fa
    I178_mu_s1_5 (mu_pp0_6 mu_pp1_5 mu_c1_4 mu_s1_5 mu_c1_5 vdd_mul vss) fa
    I179_mu_s1_6 (mu_pp0_7 mu_pp1_6 mu_c1_5 mu_s1_6 mu_c1_6 vdd_mul vss) fa
    I180_mu_s1_7 (vss mu_pp1_7 mu_c1_6 mu_s1_7 mu_c1_7 vdd_mul vss) fa
    I181_mu_s2_0 (mu_s1_1 mu_pp2_0 vss mu_s2_0 mu_c2_0 vdd_mul vss) fa
    I182_mu_s2_1 (mu_s1_2 mu_pp2_1 mu_c2_0 mu_s2_1 mu_c2_1 vdd_mul vss) fa
    I183_mu_s2_2 (mu_s1_3 mu_pp2_2 mu_c2_1 mu_s2_2 mu_c2_2 vdd_mul vss) fa
    I184_mu_s2_3 (mu_s1_4 mu_pp2_3 mu_c2_2 mu_s2_3 mu_c2_3 vdd_mul vss) fa
    I185_mu_s2_4 (mu_s1_5 mu_pp2_4 mu_c2_3 mu_s2_4 mu_c2_4 vdd_mul vss) fa
    I186_mu_s2_5 (mu_s1_6 mu_pp2_5 mu_c2_4 mu_s2_5 mu_c2_5 vdd_mul vss) fa
    I187_mu_s2_6 (mu_s1_7 mu_pp2_6 mu_c2_5 mu_s2_6 mu_c2_6 vdd_mul vss) fa
    I188_mu_s2_7 (mu_c1_7 mu_pp2_7 mu_c2_6 mu_s2_7 mu_c2_7 vdd_mul vss) fa
    I189_mu_s3_0 (mu_s2_1 mu_pp3_0 vss mu_s3_0 mu_c3_0 vdd_mul vss) fa
    I190_mu_s3_1 (mu_s2_2 mu_pp3_1 mu_c3_0 mu_s3_1 mu_c3_1 vdd_mul vss) fa
    I191_mu_s3_2 (mu_s2_3 mu_pp3_2 mu_c3_1 mu_s3_2 mu_c3_2 vdd_mul vss) fa
    I192_mu_s3_3 (mu_s2_4 mu_pp3_3 mu_c3_2 mu_s3_3 mu_c3_3 vdd_mul vss) fa
    I193_mu_s3_4 (mu_s2_5 mu_pp3_4 mu_c3_3 mu_s3_4 mu_c3_4 vdd_mul vss) fa
    I194_mu_s3_5 (mu_s2_6 mu_pp3_5 mu_c3_4 mu_s3_5 mu_c3_5 vdd_mul vss) fa
    I195_mu_s3_6 (mu_s2_7 mu_pp3_6 mu_c3_5 mu_s3_6 mu_c3_6 vdd_mul vss) fa
    I196_mu_s3_7 (mu_c2_7 mu_pp3_7 mu_c3_6 mu_s3_7 mu_c3_7 vdd_mul vss) fa
    I197_mu_s4_0 (mu_s3_1 mu_pp4_0 vss mu_s4_0 mu_c4_0 vdd_mul vss) fa
    I198_mu_s4_1 (mu_s3_2 mu_pp4_1 mu_c4_0 mu_s4_1 mu_c4_1 vdd_mul vss) fa
    I199_mu_s4_2 (mu_s3_3 mu_pp4_2 mu_c4_1 mu_s4_2 mu_c4_2 vdd_mul vss) fa
    I200_mu_s4_3 (mu_s3_4 mu_pp4_3 mu_c4_2 mu_s4_3 mu_c4_3 vdd_mul vss) fa
    I201_mu_s4_4 (mu_s3_5 mu_pp4_4 mu_c4_3 mu_s4_4 mu_c4_4 vdd_mul vss) fa
    I202_mu_s4_5 (mu_s3_6 mu_pp4_5 mu_c4_4 mu_s4_5 mu_c4_5 vdd_mul vss) fa
    I203_mu_s4_6 (mu_s3_7 mu_pp4_6 mu_c4_5 mu_s4_6 mu_c4_6 vdd_mul vss) fa
    I204_mu_s4_7 (mu_c3_7 mu_pp4_7 mu_c4_6 mu_s4_7 mu_c4_7 vdd_mul vss) fa
    I205_mu_s5_0 (mu_s4_1 mu_pp5_0 vss mu_s5_0 mu_c5_0 vdd_mul vss) fa
    I206_mu_s5_1 (mu_s4_2 mu_pp5_1 mu_c5_0 mu_s5_1 mu_c5_1 vdd_mul vss) fa
    I207_mu_s5_2 (mu_s4_3 mu_pp5_2 mu_c5_1 mu_s5_2 mu_c5_2 vdd_mul vss) fa
    I208_mu_s5_3 (mu_s4_4 mu_pp5_3 mu_c5_2 mu_s5_3 mu_c5_3 vdd_mul vss) fa
    I209_mu_s5_4 (mu_s4_5 mu_pp5_4 mu_c5_3 mu_s5_4 mu_c5_4 vdd_mul vss) fa
    I210_mu_s5_5 (mu_s4_6 mu_pp5_5 mu_c5_4 mu_s5_5 mu_c5_5 vdd_mul vss) fa
    I211_mu_s5_6 (mu_s4_7 mu_pp5_6 mu_c5_5 mu_s5_6 mu_c5_6 vdd_mul vss) fa
    I212_mu_s5_7 (mu_c4_7 mu_pp5_7 mu_c5_6 mu_s5_7 mu_c5_7 vdd_mul vss) fa
    I213_mu_s6_0 (mu_s5_1 mu_pp6_0 vss mu_s6_0 mu_c6_0 vdd_mul vss) fa
    I214_mu_s6_1 (mu_s5_2 mu_pp6_1 mu_c6_0 mu_s6_1 mu_c6_1 vdd_mul vss) fa
    I215_mu_s6_2 (mu_s5_3 mu_pp6_2 mu_c6_1 mu_s6_2 mu_c6_2 vdd_mul vss) fa
    I216_mu_s6_3 (mu_s5_4 mu_pp6_3 mu_c6_2 mu_s6_3 mu_c6_3 vdd_mul vss) fa
    I217_mu_s6_4 (mu_s5_5 mu_pp6_4 mu_c6_3 mu_s6_4 mu_c6_4 vdd_mul vss) fa
    I218_mu_s6_5 (mu_s5_6 mu_pp6_5 mu_c6_4 mu_s6_5 mu_c6_5 vdd_mul vss) fa
    I219_mu_s6_6 (mu_s5_7 mu_pp6_6 mu_c6_5 mu_s6_6 mu_c6_6 vdd_mul vss) fa
    I220_mu_s6_7 (mu_c5_7 mu_pp6_7 mu_c6_6 mu_s6_7 mu_c6_7 vdd_mul vss) fa
    I221_mu_s7_0 (mu_s6_1 mu_pp7_0 vss mu_s7_0 mu_c7_0 vdd_mul vss) fa
    I222_mu_s7_1 (mu_s6_2 mu_pp7_1 mu_c7_0 mu_s7_1 mu_c7_1 vdd_mul vss) fa
    I223_mu_s7_2 (mu_s6_3 mu_pp7_2 mu_c7_1 mu_s7_2 mu_c7_2 vdd_mul vss) fa
    I224_mu_s7_3 (mu_s6_4 mu_pp7_3 mu_c7_2 mu_s7_3 mu_c7_3 vdd_mul vss) fa
    I225_mu_s7_4 (mu_s6_5 mu_pp7_4 mu_c7_3 mu_s7_4 mu_c7_4 vdd_mul vss) fa
    I226_mu_s7_5 (mu_s6_6 mu_pp7_5 mu_c7_4 mu_s7_5 mu_c7_5 vdd_mul vss) fa
    I227_mu_s7_6 (mu_s6_7 mu_pp7_6 mu_c7_5 mu_s7_6 mu_c7_6 vdd_mul vss) fa
    I228_mu_s7_7 (mu_c6_7 mu_pp7_7 mu_c7_6 mu_s7_7 mu_c7_7 vdd_mul vss) fa
    I229_mu_or1_0 (mu_s7_1 mu_s7_2 mu_or1_0 vdd_mul vss) nor2
    I230_mu_or1_1 (mu_s7_3 mu_s7_4 mu_or1_1 vdd_mul vss) nor2
    I231_mu_or1_2 (mu_s7_5 mu_s7_6 mu_or1_2 vdd_mul vss) nor2
    I232_mu_or1_3 (mu_s7_7 mu_c7_7 mu_or1_3 vdd_mul vss) nor2
    I233_mu_or2_0 (mu_or1_0 mu_or1_1 mu_or2_0 vdd_mul vss) nand2
    I234_mu_or2_1 (mu_or1_2 mu_or1_3 mu_or2_1 vdd_mul vss) nand2
    I235_mu_or3 (mu_or2_0 mu_or2_1 mu_or3 vdd_mul vss) nor2
    I236_mu_hi_nz (mu_or3 mu_hi_nz vdd_mul vss) inv
    // ---------------- logic ----------------
    I237_lg_nota0 (lg_a0 lg_nota0 vdd_logic vss) inv
    I238_lg_nand0 (lg_a0 lg_b0 lg_nand0 vdd_logic vss) nand2
    I239_lg_nor0 (lg_a0 lg_b0 lg_nor0 vdd_logic vss) nor2
    I240_lg_xnor0 (lg_a0 lg_b0 lg_xnor0 vdd_logic vss) xnor2
    I241_lg_m0 (OP1 OP0 lg_nota0 lg_nand0 lg_nor0 lg_xnor0 lg_m0 vdd_logic vss) mux4
    I242_lg_y0 (lg_m0 nOP3 lg_y0 vdd_logic vss) xor2
    I243_lg_nota1 (lg_a1 lg_nota1 vdd_logic vss) inv
    I244_lg_nand1 (lg_a1 lg_b1 lg_nand1 vdd_logic vss) nand2
    I245_lg_nor1 (lg_a1 lg_b1 lg_nor1 vdd_logic vss) nor2
    I246_lg_xnor1 (lg_a1 lg_b1 lg_xnor1 vdd_logic vss) xnor2
    I247_lg_m1 (OP1 OP0 lg_nota1 lg_nand1 lg_nor1 lg_xnor1 lg_m1 vdd_logic vss) mux4
    I248_lg_y1 (lg_m1 nOP3 lg_y1 vdd_logic vss) xor2
    I249_lg_nota2 (lg_a2 lg_nota2 vdd_logic vss) inv
    I250_lg_nand2 (lg_a2 lg_b2 lg_nand2 vdd_logic vss) nand2
    I251_lg_nor2 (lg_a2 lg_b2 lg_nor2 vdd_logic vss) nor2
    I252_lg_xnor2 (lg_a2 lg_b2 lg_xnor2 vdd_logic vss) xnor2
    I253_lg_m2 (OP1 OP0 lg_nota2 lg_nand2 lg_nor2 lg_xnor2 lg_m2 vdd_logic vss) mux4
    I254_lg_y2 (lg_m2 nOP3 lg_y2 vdd_logic vss) xor2
    I255_lg_nota3 (lg_a3 lg_nota3 vdd_logic vss) inv
    I256_lg_nand3 (lg_a3 lg_b3 lg_nand3 vdd_logic vss) nand2
    I257_lg_nor3 (lg_a3 lg_b3 lg_nor3 vdd_logic vss) nor2
    I258_lg_xnor3 (lg_a3 lg_b3 lg_xnor3 vdd_logic vss) xnor2
    I259_lg_m3 (OP1 OP0 lg_nota3 lg_nand3 lg_nor3 lg_xnor3 lg_m3 vdd_logic vss) mux4
    I260_lg_y3 (lg_m3 nOP3 lg_y3 vdd_logic vss) xor2
    I261_lg_nota4 (lg_a4 lg_nota4 vdd_logic vss) inv
    I262_lg_nand4 (lg_a4 lg_b4 lg_nand4 vdd_logic vss) nand2
    I263_lg_nor4 (lg_a4 lg_b4 lg_nor4 vdd_logic vss) nor2
    I264_lg_xnor4 (lg_a4 lg_b4 lg_xnor4 vdd_logic vss) xnor2
    I265_lg_m4 (OP1 OP0 lg_nota4 lg_nand4 lg_nor4 lg_xnor4 lg_m4 vdd_logic vss) mux4
    I266_lg_y4 (lg_m4 nOP3 lg_y4 vdd_logic vss) xor2
    I267_lg_nota5 (lg_a5 lg_nota5 vdd_logic vss) inv
    I268_lg_nand5 (lg_a5 lg_b5 lg_nand5 vdd_logic vss) nand2
    I269_lg_nor5 (lg_a5 lg_b5 lg_nor5 vdd_logic vss) nor2
    I270_lg_xnor5 (lg_a5 lg_b5 lg_xnor5 vdd_logic vss) xnor2
    I271_lg_m5 (OP1 OP0 lg_nota5 lg_nand5 lg_nor5 lg_xnor5 lg_m5 vdd_logic vss) mux4
    I272_lg_y5 (lg_m5 nOP3 lg_y5 vdd_logic vss) xor2
    I273_lg_nota6 (lg_a6 lg_nota6 vdd_logic vss) inv
    I274_lg_nand6 (lg_a6 lg_b6 lg_nand6 vdd_logic vss) nand2
    I275_lg_nor6 (lg_a6 lg_b6 lg_nor6 vdd_logic vss) nor2
    I276_lg_xnor6 (lg_a6 lg_b6 lg_xnor6 vdd_logic vss) xnor2
    I277_lg_m6 (OP1 OP0 lg_nota6 lg_nand6 lg_nor6 lg_xnor6 lg_m6 vdd_logic vss) mux4
    I278_lg_y6 (lg_m6 nOP3 lg_y6 vdd_logic vss) xor2
    I279_lg_nota7 (lg_a7 lg_nota7 vdd_logic vss) inv
    I280_lg_nand7 (lg_a7 lg_b7 lg_nand7 vdd_logic vss) nand2
    I281_lg_nor7 (lg_a7 lg_b7 lg_nor7 vdd_logic vss) nor2
    I282_lg_xnor7 (lg_a7 lg_b7 lg_xnor7 vdd_logic vss) xnor2
    I283_lg_m7 (OP1 OP0 lg_nota7 lg_nand7 lg_nor7 lg_xnor7 lg_m7 vdd_logic vss) mux4
    I284_lg_y7 (lg_m7 nOP3 lg_y7 vdd_logic vss) xor2
    // ---------------- shift ----------------
    I285_sh_fill (OP1 sh_a7 sh_fill vdd_shift vss) and2
    I286_sh_m0 (OP0 sh_fill sh_a1 sh_m0 vdd_shift vss) mux2
    I287_sh_y0 (sh_m0 sh_y0 vdd_shift vss) buf
    I288_sh_m1 (OP0 sh_a0 sh_a2 sh_m1 vdd_shift vss) mux2
    I289_sh_y1 (sh_m1 sh_y1 vdd_shift vss) buf
    I290_sh_m2 (OP0 sh_a1 sh_a3 sh_m2 vdd_shift vss) mux2
    I291_sh_y2 (sh_m2 sh_y2 vdd_shift vss) buf
    I292_sh_m3 (OP0 sh_a2 sh_a4 sh_m3 vdd_shift vss) mux2
    I293_sh_y3 (sh_m3 sh_y3 vdd_shift vss) buf
    I294_sh_m4 (OP0 sh_a3 sh_a5 sh_m4 vdd_shift vss) mux2
    I295_sh_y4 (sh_m4 sh_y4 vdd_shift vss) buf
    I296_sh_m5 (OP0 sh_a4 sh_a6 sh_m5 vdd_shift vss) mux2
    I297_sh_y5 (sh_m5 sh_y5 vdd_shift vss) buf
    I298_sh_m6 (OP0 sh_a5 sh_a7 sh_m6 vdd_shift vss) mux2
    I299_sh_y6 (sh_m6 sh_y6 vdd_shift vss) buf
    I300_sh_m7 (OP0 sh_a6 vss sh_m7 vdd_shift vss) mux2
    I301_sh_y7 (sh_m7 sh_y7 vdd_shift vss) buf
    I302_sh_c (OP0 sh_a7 sh_a0 sh_c vdd_shift vss) mux2
    // ---------------- ctrl ----------------
    I303_SEL0 (EN_MUL EN_SHIFT SEL0 vdd_ctrl vss) or2
    I304_SEL1 (EN_LOGIC EN_SHIFT SEL1 vdd_ctrl vss) or2
    I305_Y0 (SEL1 SEL0 ar_s0 mu_pp0_0 lg_y0 sh_y0 Y0 vdd_ctrl vss) mux4
    I306_Y1 (SEL1 SEL0 ar_s1 mu_s1_0 lg_y1 sh_y1 Y1 vdd_ctrl vss) mux4
    I307_Y2 (SEL1 SEL0 ar_s2 mu_s2_0 lg_y2 sh_y2 Y2 vdd_ctrl vss) mux4
    I308_Y3 (SEL1 SEL0 ar_s3 mu_s3_0 lg_y3 sh_y3 Y3 vdd_ctrl vss) mux4
    I309_Y4 (SEL1 SEL0 ar_s4 mu_s4_0 lg_y4 sh_y4 Y4 vdd_ctrl vss) mux4
    I310_Y5 (SEL1 SEL0 ar_s5 mu_s5_0 lg_y5 sh_y5 Y5 vdd_ctrl vss) mux4
    I311_Y6 (SEL1 SEL0 ar_s6 mu_s6_0 lg_y6 sh_y6 Y6 vdd_ctrl vss) mux4
    I312_Y7 (SEL1 SEL0 ar_s7 mu_s7_0 lg_y7 sh_y7 Y7 vdd_ctrl vss) mux4
    I313_YH0 (mu_s7_1 EN_MUL YH0 vdd_ctrl vss) and2
    I314_YH1 (mu_s7_2 EN_MUL YH1 vdd_ctrl vss) and2
    I315_YH2 (mu_s7_3 EN_MUL YH2 vdd_ctrl vss) and2
    I316_YH3 (mu_s7_4 EN_MUL YH3 vdd_ctrl vss) and2
    I317_YH4 (mu_s7_5 EN_MUL YH4 vdd_ctrl vss) and2
    I318_YH5 (mu_s7_6 EN_MUL YH5 vdd_ctrl vss) and2
    I319_YH6 (mu_s7_7 EN_MUL YH6 vdd_ctrl vss) and2
    I320_YH7 (mu_c7_7 EN_MUL YH7 vdd_ctrl vss) and2
    I321_C (SEL1 SEL0 ar_c8 mu_hi_nz vss sh_c C vdd_ctrl vss) mux4
    I322_V (SEL1 SEL0 ar_v mu_hi_nz vss vss V vdd_ctrl vss) mux4
    I323_z1_0 (Y0 Y1 z1_0 vdd_ctrl vss) nor2
    I324_z1_1 (Y2 Y3 z1_1 vdd_ctrl vss) nor2
    I325_z1_2 (Y4 Y5 z1_2 vdd_ctrl vss) nor2
    I326_z1_3 (Y6 Y7 z1_3 vdd_ctrl vss) nor2
    I327_z1_4 (YH0 YH1 z1_4 vdd_ctrl vss) nor2
    I328_z1_5 (YH2 YH3 z1_5 vdd_ctrl vss) nor2
    I329_z1_6 (YH4 YH5 z1_6 vdd_ctrl vss) nor2
    I330_z1_7 (YH6 YH7 z1_7 vdd_ctrl vss) nor2
    I331_z2_0 (z1_0 z1_1 z2_0 vdd_ctrl vss) nand2
    I332_z2_1 (z1_2 z1_3 z2_1 vdd_ctrl vss) nand2
    I333_z2_2 (z1_4 z1_5 z2_2 vdd_ctrl vss) nand2
    I334_z2_3 (z1_6 z1_7 z2_3 vdd_ctrl vss) nand2
    I335_z3_0 (z2_0 z2_1 z3_0 vdd_ctrl vss) nor2
    I336_z3_1 (z2_2 z2_3 z3_1 vdd_ctrl vss) nor2
    I337_z4 (z3_0 z3_1 z4 vdd_ctrl vss) nand2
    I338_Z (z4 Z vdd_ctrl vss) inv
    I339_nEN_MUL (EN_MUL nEN_MUL vdd_ctrl vss) inv
    I340_N (Y7 nEN_MUL N vdd_ctrl vss) and2
ends alu8
