// CMOS cells for the low-power 8-bit ALU  (generated by gen_netlist.py)
// PDK preset: nmos=g45n1svt pmos=g45p1svt  L=45n  Wn=120n  Wp=240n (minimum size = low power)
simulator lang=spectre

// inverter, 2T
subckt inv (a y vdd vss)
    MP (y a vdd vdd) g45p1svt w=240n l=45n
    MN (y a vss vss) g45n1svt w=120n l=45n
ends inv

// buffer, 4T
subckt buf (a y vdd vss)
    MP1 (x a vdd vdd) g45p1svt w=240n l=45n
    MN1 (x a vss vss) g45n1svt w=120n l=45n
    MP2 (y x vdd vdd) g45p1svt w=240n l=45n
    MN2 (y x vss vss) g45n1svt w=120n l=45n
ends buf

// NAND2, 4T
subckt nand2 (a b y vdd vss)
    MP1 (y a vdd vdd) g45p1svt w=240n l=45n
    MP2 (y b vdd vdd) g45p1svt w=240n l=45n
    MN1 (y a x vss) g45n1svt w=120n l=45n
    MN2 (x b vss vss) g45n1svt w=120n l=45n
ends nand2

// NOR2, 4T
subckt nor2 (a b y vdd vss)
    MP1 (x a vdd vdd) g45p1svt w=240n l=45n
    MP2 (y b x vdd) g45p1svt w=240n l=45n
    MN1 (y a vss vss) g45n1svt w=120n l=45n
    MN2 (y b vss vss) g45n1svt w=120n l=45n
ends nor2

// AND2 = NAND2 + INV, 6T (also used as operand-isolation gate)
subckt and2 (a b y vdd vss)
    MP1 (x a vdd vdd) g45p1svt w=240n l=45n
    MP2 (x b vdd vdd) g45p1svt w=240n l=45n
    MN1 (x a x1 vss) g45n1svt w=120n l=45n
    MN2 (x1 b vss vss) g45n1svt w=120n l=45n
    MP3 (y x vdd vdd) g45p1svt w=240n l=45n
    MN3 (y x vss vss) g45n1svt w=120n l=45n
ends and2

// OR2 = NOR2 + INV, 6T
subckt or2 (a b y vdd vss)
    MP1 (x1 a vdd vdd) g45p1svt w=240n l=45n
    MP2 (x b x1 vdd) g45p1svt w=240n l=45n
    MN1 (x a vss vss) g45n1svt w=120n l=45n
    MN2 (x b vss vss) g45n1svt w=120n l=45n
    MP3 (y x vdd vdd) g45p1svt w=240n l=45n
    MN3 (y x vss vss) g45n1svt w=120n l=45n
ends or2

// static CMOS XOR2, 12T
subckt xor2 (a b y vdd vss)
    MPA (an a vdd vdd) g45p1svt w=240n l=45n
    MNA (an a vss vss) g45n1svt w=120n l=45n
    MPB (bn b vdd vdd) g45p1svt w=240n l=45n
    MNB (bn b vss vss) g45n1svt w=120n l=45n
    MN1 (y a x1 vss) g45n1svt w=120n l=45n
    MN2 (x1 b vss vss) g45n1svt w=120n l=45n
    MN3 (y an x2 vss) g45n1svt w=120n l=45n
    MN4 (x2 bn vss vss) g45n1svt w=120n l=45n
    MP1 (x3 a vdd vdd) g45p1svt w=240n l=45n
    MP2 (x3 b vdd vdd) g45p1svt w=240n l=45n
    MP3 (y an x3 vdd) g45p1svt w=240n l=45n
    MP4 (y bn x3 vdd) g45p1svt w=240n l=45n
ends xor2

// static CMOS XNOR2, 12T
subckt xnor2 (a b y vdd vss)
    MPA (an a vdd vdd) g45p1svt w=240n l=45n
    MNA (an a vss vss) g45n1svt w=120n l=45n
    MPB (bn b vdd vdd) g45p1svt w=240n l=45n
    MNB (bn b vss vss) g45n1svt w=120n l=45n
    MN1 (y a x1 vss) g45n1svt w=120n l=45n
    MN2 (x1 bn vss vss) g45n1svt w=120n l=45n
    MN3 (y an x2 vss) g45n1svt w=120n l=45n
    MN4 (x2 b vss vss) g45n1svt w=120n l=45n
    MP1 (x3 a vdd vdd) g45p1svt w=240n l=45n
    MP2 (x3 bn vdd vdd) g45p1svt w=240n l=45n
    MP3 (y an x3 vdd) g45p1svt w=240n l=45n
    MP4 (y b x3 vdd) g45p1svt w=240n l=45n
ends xnor2

// transmission-gate 2:1 mux, 6T  (sel=0 -> d0, sel=1 -> d1)
subckt mux2 (sel d0 d1 y vdd vss)
    MPI (seln sel vdd vdd) g45p1svt w=240n l=45n
    MNI (seln sel vss vss) g45n1svt w=120n l=45n
    MN0 (y seln d0 vss) g45n1svt w=120n l=45n
    MP0 (y sel d0 vdd) g45p1svt w=240n l=45n
    MN1 (y sel d1 vss) g45n1svt w=120n l=45n
    MP1 (y seln d1 vdd) g45p1svt w=240n l=45n
ends mux2

// transmission-gate 4:1 mux + restoring buffer, 22T  (y = d[2*s1+s0])
subckt mux4 (s1 s0 d0 d1 d2 d3 y vdd vss)
    I0 (s0 d0 d1 m0 vdd vss) mux2
    I1 (s0 d2 d3 m1 vdd vss) mux2
    I2 (s1 m0 m1 m2 vdd vss) mux2
    MPB1 (m3 m2 vdd vdd) g45p1svt w=240n l=45n
    MNB1 (m3 m2 vss vss) g45n1svt w=120n l=45n
    MPB2 (y m3 vdd vdd) g45p1svt w=240n l=45n
    MNB2 (y m3 vss vss) g45n1svt w=120n l=45n
ends mux4

// 28T mirror full adder
subckt fa (a b ci s co vdd vss)
    // carry (mirror):  cn = ~(a.b + ci.(a+b))
    MN1 (x1 a vss vss) g45n1svt w=120n l=45n
    MN2 (x1 b vss vss) g45n1svt w=120n l=45n
    MN3 (cn ci x1 vss) g45n1svt w=120n l=45n
    MN4 (cn a x2 vss) g45n1svt w=120n l=45n
    MN5 (x2 b vss vss) g45n1svt w=120n l=45n
    MP1 (x3 a vdd vdd) g45p1svt w=240n l=45n
    MP2 (x3 b vdd vdd) g45p1svt w=240n l=45n
    MP3 (cn ci x3 vdd) g45p1svt w=240n l=45n
    MP4 (cn a x4 vdd) g45p1svt w=240n l=45n
    MP5 (x4 b vdd vdd) g45p1svt w=240n l=45n
    // sum (mirror):  sn = ~(a.b.ci + cn.(a+b+ci))
    MN6 (x5 a vss vss) g45n1svt w=120n l=45n
    MN7 (x5 b vss vss) g45n1svt w=120n l=45n
    MN8 (x5 ci vss vss) g45n1svt w=120n l=45n
    MN9 (sn cn x5 vss) g45n1svt w=120n l=45n
    MN10 (sn a x6 vss) g45n1svt w=120n l=45n
    MN11 (x6 b x7 vss) g45n1svt w=120n l=45n
    MN12 (x7 ci vss vss) g45n1svt w=120n l=45n
    MP6 (x8 a vdd vdd) g45p1svt w=240n l=45n
    MP7 (x8 b vdd vdd) g45p1svt w=240n l=45n
    MP8 (x8 ci vdd vdd) g45p1svt w=240n l=45n
    MP9 (sn cn x8 vdd) g45p1svt w=240n l=45n
    MP10 (sn a x9 vdd) g45p1svt w=240n l=45n
    MP11 (x9 b x10 vdd) g45p1svt w=240n l=45n
    MP12 (x10 ci vdd vdd) g45p1svt w=240n l=45n
    // output inverters
    MP13 (co cn vdd vdd) g45p1svt w=240n l=45n
    MN13 (co cn vss vss) g45n1svt w=120n l=45n
    MP14 (s sn vdd vdd) g45p1svt w=240n l=45n
    MN14 (s sn vss vss) g45n1svt w=120n l=45n
ends fa
