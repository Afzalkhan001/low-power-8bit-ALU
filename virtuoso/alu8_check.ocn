;; OCEAN check script for the 8-bit ALU (generated by gen_netlist.py)
;; Usage (from this folder, after running spectre):
;;   ocean
;;   > resDir = "./psf"        ; or "./psf_noiso"
;;   > load("alu8_check.ocn")
;; It samples every output near the end of each 10 ns slot, compares with the
;; golden model, then prints average power per block and the worst-case ADD delay.

unless( boundp('resDir) resDir = "./psf" )
vdd = 1.0
T   = 10e-9
openResults(resDir)
selectResult('tran)

procedure( aluBit(sig t)
  if( value(getData(sig ?result 'tran) t) > vdd/2.0 then 1 else 0)
)
procedure( aluByte(prefix t)
  let( ((acc 0))
    for( i 0 7  acc = acc + leftshift(aluBit(sprintf(nil "%s%d" prefix i) t) i) )
    acc)
)

expected = list(
  list(0 "ADD" 45 23 68 0 0 0 0 0 1)
  list(1 "ADD" 255 1 0 0 1 1 0 0 1)
  list(2 "ADD" 127 1 128 0 0 0 1 1 1)
  list(3 "SUB" 45 23 22 0 1 0 0 0 1)
  list(4 "SUB" 23 45 234 0 0 0 1 0 1)
  list(5 "SUB" 128 1 127 0 1 0 0 1 1)
  list(6 "INC" 15 0 16 0 0 0 0 0 1)
  list(7 "INC" 255 0 0 0 1 1 0 0 1)
  list(8 "DEC" 16 0 15 0 1 0 0 0 1)
  list(9 "DEC" 0 0 255 0 0 0 1 0 1)
  list(10 "MUL" 12 11 132 0 0 0 0 0 1)
  list(11 "MUL" 255 255 1 254 1 0 0 1 1)
  list(12 "MUL" 16 16 0 1 1 0 0 1 1)
  list(13 "AND" 202 95 74 0 0 0 0 0 1)
  list(14 "OR" 202 95 223 0 0 0 1 0 1)
  list(15 "XOR" 202 95 149 0 0 0 1 0 1)
  list(16 "XOR" 170 170 0 0 0 1 0 0 1)
  list(17 "NOT" 202 0 53 0 0 0 0 0 1)
  list(18 "NAND" 202 95 181 0 0 0 1 0 1)
  list(19 "NOR" 202 95 32 0 0 0 0 0 1)
  list(20 "XNOR" 202 95 106 0 0 0 0 0 1)
  list(21 "SHL" 129 0 2 0 1 0 0 0 1)
  list(22 "SHR" 129 0 64 0 1 0 0 0 1)
  list(23 "ROL" 129 0 3 0 1 0 0 0 1)
  list(24 "ROL" 64 0 128 0 0 0 1 0 1)
  list(25 "CMP" 55 55 0 0 1 1 0 0 0)
  list(26 "CMP" 16 32 240 0 0 0 1 0 0)
  list(27 "CMP" 32 16 16 0 1 0 0 0 0)
  list(28 "ADD" 0 0 0 0 0 1 0 0 1)
  list(29 "MUL" 165 90 2 58 1 0 0 1 1)
)

errors = 0
printf("\n idx op    A    B  |  Y  (exp)  YH (exp) | C Z N V WE | result\n")
foreach( vec expected
  k  = nth(0 vec)
  t  = (k + 1) * T - 1e-9
  y  = aluByte("Y" t)
  yh = aluByte("YH" t)
  fl = list(aluBit("C" t) aluBit("Z" t) aluBit("N" t) aluBit("V" t) aluBit("WE" t))
  ok = (y == nth(4 vec)) && (yh == nth(5 vec)) && (fl == list(nth(6 vec) nth(7 vec) nth(8 vec) nth(9 vec) nth(10 vec)))
  unless( ok errors = errors + 1 )
  printf("%3d %-4s %4d %4d | %3d (%3d) %3d (%3d) | %d %d %d %d %d  | %s\n"
    k nth(1 vec) nth(2 vec) nth(3 vec) y nth(4 vec) yh nth(5 vec)
    nth(0 fl) nth(1 fl) nth(2 fl) nth(3 fl) nth(4 fl) if(ok "PASS" "FAIL"))
)
printf("\nFunctional check: %d / %d vectors failed\n" errors length(expected))

;; ---- average power per block (P = -avg(I) * VDD; supply current flows out of the + pin)
total = 0.0
foreach( blk list("ctrl" "arith" "mul" "logic" "shift")
  pw = -average(getData(sprintf(nil "V%s:p" blk) ?result 'tran)) * vdd
  total = total + pw
  printf("  P(%-5s) = %8.3f uW\n" blk pw*1e6)
)
printf("  P(total) = %8.3f uW   energy/op = %.3f pJ\n" total*1e6 total*T*1e12)

;; ---- worst-case carry ripple: vector 1 is ADD FF+01 -> Z rises after the carry ripples 8 stages
tz = cross(clip(getData("Z" ?result 'tran) T 2*T) vdd/2.0 1 'rising)
printf("  ADD FF+01 carry-ripple delay (input edge -> Z) = %.1f ps\n" (tz - T)*1e12)
